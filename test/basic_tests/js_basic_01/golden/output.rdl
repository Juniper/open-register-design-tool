/*   Ordt 180327.01 autogenerated file 
 *   Input: ./js_basic_01/test.js
 *   Parms: ./js_basic_01/test.parms
 *   Date: Tue Mar 27 14:56:04 EDT 2018
 */

// address map simple1
addrmap {

  name = "Registers for simple1";
  // register set stats
  regfile {
  
    name = "stats register_set";
    // register disable_check
    reg {
    
      name = "disable_check register";
      field {
        name = "timer_sram field";
        sw=rw; 
      } timer_sram [0:0] =0x0;
      
      field {
        name = "cbuf_fifo field";
        sw=rw; 
      } cbuf_fifo [1:1] =0x0;
      
      field {
        name = "lut_st field";
        sw=rw; 
      } lut_st [2:2] =0x0;
      
      field {
        name = "l0_b0 field";
        sw=rw; 
      } l0_b0 [3:3] =0x0;
      
      field {
        name = "l0_b1 field";
        sw=rw; 
      } l0_b1 [4:4] =0x0;
      
      field {
        name = "l0_b2 field";
        sw=rw; 
      } l0_b2 [5:5] =0x0;
      
      field {
        name = "l0_b3 field";
        sw=rw; 
      } l0_b3 [6:6] =0x0;
      
    } disable_check[2] @0x0;
    
    // register features
    reg {
    
      name = "features register";
      field {
        name = "adr_logged field";
        sw=r; 
      } adr_logged [0:0] =0x1;
      
      field {
        name = "correctable field";
        sw=r; 
      } correctable [1:1] =0x0;
      
      field {
        name = "checker field";
        sw=r; 
      } checker [2:2] =0x1;
      
      field {
        name = "generator field";
        sw=r; 
      } generator [3:3] =0x1;
      
      field {
        name = "wdth field";
        sw=r; 
      } wdth [8:4] =0x7;
      
      field {
        name = "syn_logged field";
        sw=r; 
      } syn_logged [9:9] =0x0;
      
      field {
        name = "version field";
        sw=r; 
      } version [31:30] =0x2;
      
    } features @0x100;
    
    // register log_address1
    reg {
    
      name = "log_address1 register";
      desc = "
        newdesc bla bla
      ";
      category = "STATE";
      field {
        name = "value field";
        sw=rw; 
      } value [9:0] =0x0;
      
    } log_address1 @0x104;
    
    // register log_address2
    reg {
    
      name = "log_address2 register";
      desc = "
        newdesc 2 bla bla
      ";
      category = "STATE";
      field {
        name = "value field";
        sw=rw; 
      } value [9:0] =0x0;
      
    } log_address2 @0x110;
    
    // register wide_reg
    reg {
    
      name = "wide_reg register";
      regwidth = 128;
      field {
        name = "value field";
        sw=rw; 
      } value [95:0] =0xa5a5a5a5a5a5a5a5a5a5a5a5;
      
    } wide_reg @0x120;
    
  } stats @0x1000;
  
  // register set rdr
  regfile {
  
    name = "rdr register_set";
    // register reorder_window
    reg {
    
      name = "reorder_window register";
      category = "STATE";
      field {
        name = "size field";
        desc = "
          SW Configuration field
        ";
        sw=rw; 
      } size [10:0] =0x80;
      
      field {
        name = "set_back field";
        desc = "
          SW Configuration field
        ";
        sw=rw; 
      } set_back [26:16] =0x10;
      
      field {
        name = "ws_enable field";
        desc = "
          SW Configuration field
        ";
        sw=rw; 
      } ws_enable [31:31] =0x1;
      
    } reorder_window @0x0;
    
    // register stream_reconf
    reg {
    
      name = "stream_reconf register";
      field {
        name = "stream field";
        desc = "
          SW Configuration field
        ";
        sw=rw; 
      } stream [9:0] =0x0;
      
      field {
        name = "busy field";
        desc = "
          HW Status field
        ";
        sw=r; 
      } busy [16:16] =0x0;
      
    } stream_reconf @0x4;
    
    // register set cp_fp_wr
    regfile {
    
      name = "cp_fp_wr register_set";
      // register buffer
      reg {
      
        name = "buffer register";
        category = "STATE";
        field {
          name = "addr1 field";
          desc = "
            HW Status field
          ";
          sw=r; 
        } addr1 [10:0];
        
        field {
          name = "addr0 field";
          desc = "
            HW Status field
          ";
          sw=r; 
        } addr0 [26:16];
        
      } buffer[4] @0x0;
      
    } cp_fp_wr @0x21c0;
    
    // register roll32_counter_reg
    reg {
    
      name = "roll32_counter_reg register";
      field {
        name = "count field";
        sw=rw; 
      } count [3:0] =0x0;
      
    } roll32_counter_reg @0x21d0;
    
    // register sat32_counter_reg
    reg {
    
      name = "sat32_counter_reg register";
      dontcompare;
      field {
        name = "count field";
        dontcompare;
        sw=rw; rclr;
      } count [3:0] =0x0;
      
    } sat32_counter_reg @0x21d4;
    
    // register rcnt_sat_log
    reg {
    
      name = "rcnt_sat_log register";
      field {
        name = "count field";
        sw=rw; rclr;
      } count [15:0] =0x0;
      
      field {
        name = "str field";
        sw=rw; rclr;
        sub_category = "INFO";
      } str [25:16] =0x0;
      
      field {
        name = "subch field";
        sw=rw; rclr;
      } subch [30:26] =0x0;
      
      field {
        name = "en field";
        desc = "
          SW Configuration field
        ";
        sw=rw; 
      } en [31:31] =0x1;
      
    } rcnt_sat_log @0x21d8;
    
  } rdr @0x4000;
  
  // register extra_reg
  reg {
  
    name = "extra_reg name";
    desc = "
      extra_reg description bla bla bla
                more bla
    ";
    category = "DYNAMIC_CONFIG";
    field {
      name = "value field";
      desc = "
        SW Configuration field
      ";
      sw=rw; 
    } value [31:0];
    
  } extra_reg @0x61dc;
  
} simple1;

