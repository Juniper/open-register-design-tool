// ---- top down generation of hierarchical address maps for test
//      adds single register child addrmaps, gated clock option
//      also PARALLEL external options
//

// define a config reg
reg config_reg{
   name = "Config reg set  %instance";
   field {
      name = "Bunch o lsb bits";
      sw=rw; hw=r; //swacc; swmod;
   } lsb_field[16] = 16'hffff;
   field {
      name = "Bunch o msb bits";
      sw=rw; hw=r;
   } msb_field[16] = 16'h0;
};

// define a state reg
reg state_reg{
   name = "State reg";
   field {
      name = "Some state bits";
      sw=r; hw=w;
   } lsb_field[16] = 16'hffff;
};

// define a regfile containing arrays of config and state regs
regfile base_regs {   
    config_reg config_regs[8];
    //config_regs->name = "Config regs";
    state_reg state_regs[8] @0x100;
    state_regs->name = "State regs";
};

// define a regfile with only one reg
addrmap singleton_rf {   
    //base_regs base_regs;
    //config_reg config_reg[2];
    reg {
       field {  sw=rw; hw=r; } lsb_field[16] = 16'hffff;
       field { sw=rw; hw=r; } msb_field[16] = 16'h0;
    } sing_reg;
};

// define level 3 addrmap - base regs and ext region
addrmap l3_map {
    name = "L3 regs";
    
    base_regs base_regs;
    external base_regs ext_base_regs @0x800;
};

// define level 2 addrmap - base regs, ext region, and p2p child
addrmap l2_map {
    name = "L2 regs";
    
    base_regs base_regs;
    external base_regs ext_base_regs @0x1000;
    external(SERIAL8 dly=1) l3_map l3_child @0x2000;
};

// define level 1 addrmap - base regs, ext region, and p2p child
addrmap l1_map {
    name = "L1 regs";
    
    base_regs base_regs;
    external base_regs ext_base_regs @0x10000;
    external(RING16 dly=2) l2_map l2_r16_child @0x20000;
    external(SERIAL8 dly=1) l2_map l2_s8_child @0x30000;
    external(DEFAULT) l2_map l2_dflt_child @0x40000;
    external(SERIAL8 dly=1) singleton_rf singleton_rf_s8 @0x50000;
    external(RING16 dly=1) singleton_rf singleton_rf_r16 @0x60000;
    external(DEFAULT) singleton_rf singleton_rf_dflt @0x70000;
     
    // regfile replications / field data options test
    regfile {
       regfile {
          external(PARALLEL field_data=YES) config_reg reg_dflt @0x0;  // create 8 separate external interfaces (1 per reg_l2*reg_l1) - no address
          external(PARALLEL rep_level=1) config_reg reg_l1 @0x8;  // create 2 external interfaces (1 per reg_l2) - 2b address
          external(PARALLEL field_data=YES rep_level=2) config_reg reg_l2 @0x10;  // create a single combined interface - 3b address
          //external(PARALLEL) config_reg reg_l1 @0x8; 
          //external(PARALLEL) config_reg reg_l2 @0x10; 
       } rf_lvl1[4] +=0x80;
    } rf_lvl2[2] @0x80000 +=0x1000;
    
} base_map;
